{
    name: "eth_idma",
    clock_primary: "msoc_clk",
    reset_primary: "rst_int",
    bus_interfaces: [
        { protocol: "reg_iface", direction: "device"}
    ]
    regwidth: "32",
    registers: [
        { name: "low_addr",
          desc: "lower 4 bytes of the devices MAC address",
          swaccess: "rw",
          hwaccess: "hrw",
          fields: [
              { bits: "31:0", name: "lower_mac_address",
                desc: "Lower 32 bit of the devices MAC address"
                resval: "0x00890702"
              }
          ]
        },
        { name: "machi",
          desc: "upper 2 bytes of the devices MAC address, cooked, loopback, promiscuous flag, irq_en",
          swaccess: "rw",
          hwaccess: "hrw",
          fields: [
              { bits: "15:0", name: "upper_addr",
                desc: "Upper 16 bit of the devices MAC address",
                resval: "0x2301"
              },
              { bits: "16", name: "cooked",
                desc: "obsolete flag",
                resval: "0"
              },
              { bits: "17", name: "loopback",
                desc: "enable the reception of loopback packet",
                resval: "0"
              },

              { bits: "21:18", name: "spare",
                desc: "promiscuous flag",
                resval: "0"
              },
              { bits: "22", name: "promiscuous",
                desc: "enable the reception of all packets",
                resval: "0"
              },
              { bits: "23", name: "irq_en",
                desc: "interrupt enbale",
                resval: "0"
              }   
          ]
        },
        { name: "mdio",
          desc: "mdio control register",
          swaccess: "rw",
          hwaccess: "hrw",
          fields: [
              { bits: "0", name: "mdio_clk",
                desc: "MDIO clk",
                resval: "0"
              },
              { bits: "1", name: "mdio_o",
                desc: "MDIO output",
                resval: "0"
              },
              { bits: "2", name: "mdio_oe",
                desc: "MDIO output enable",
                resval: "0"
              },
              { bits: "3", name: "mdio_i",
                desc: "MDIO input",
                swaccess: "ro",
                hwaccess: "hrw"
              }
          ]
        },
        { name: "tx_busy",
          desc: "TX busy",
          swaccess: "ro",
          hwaccess: "hwo",
          fields: [
              { bits: "0", name: "tx_busy",
                desc: "TX busy transmitting packets"
                resval: "0"
              }
          ]
        },
        { name: "tx_fcs",
          desc: "TX frame check register",
          swaccess: "ro",
          hwaccess: "hwo",
          fields: [
              { bits: "31:0", name: "tx_fcs",
                desc: "FCS TX status"
                resval: "0"
              }
          ]
        },
        { name: "rx_fcs",
          desc: "RX frame check register",
          swaccess: "ro",
          hwaccess: "hwo",
          fields: [
              { bits: "31:0", name: "rx_fcs",
                desc: "FCS RX status"
                resval: "0"
              }
          ]
        },
        { name: "rsr",
          desc: "receive status register",
          swaccess: "ro",
          hwaccess: "hwo",
          fields: [
              { bits: "0", name: "rx_complete",
                desc: "reception completes"
                resval: "0"
              }
              { bits: "1", name: "rx_irq",
                desc: "etherent rx interrupt"
                resval: "0"
              }
          ]
        },
        { name: "src_addr",
          desc: "Source Address",
          swaccess: "rw",
          hwaccess: "hro",
          fields: [
            { bits: "31:0",
              name: "src_addr",
              desc: "Source Address"
              resval: "0"
            }
          ]
        },
        { name: "dst_addr",
          desc: "Destination Address",
          swaccess: "rw",
          hwaccess: "hro",
          fields: [
            { bits: "31:0",
              name: "dst_addr",
              desc: "Destination Address"
              resval: "0"
            }
          ]
        },
        { name: "length",
          desc: "Number of bytes",
          swaccess: "rw",
          hwaccess: "hrw",
          fields: [
            { bits: "11:0",
              name: "num_bytes",
              desc: "Number of bytes"
              resval: "0"
            }
          ]
        },
        { name: "src_protocol",
          desc: "Source protocol of iDMA",
          swaccess: "rw",
          hwaccess: "hro",
          fields: [
            { bits: "2:0",
              name: "src_protocol",
              desc: "iDMA source protocol"
              resval: "0"
            }
          ]
        },
        { name: "dst_protocol",
          desc: "Destination protocol of iDMA",
          swaccess: "rw",
          hwaccess: "hro",
          fields: [
            { bits: "2:0",
              name: "dst_protocol",
              desc: "iDMA destination protocol "
              resval: "0"
            }
          ]
        },
        { name: "axi_id",
          desc: "iDMA transaction ID",
          swaccess: "rw",
          hwaccess: "hrw",
          fields: [
            { bits: "0",
              name: "axi_id",
              desc: "transaction ID"
              resval: "0"
            }
          ]
        },
        { name: "opt_src",
          desc: "src options",
          swaccess: "rw",
          hwaccess: "hro",
          fields: [
           { bits: "1:0", name: "burst",
             desc: "burst opt"
             resval: "1"
           },
           { bits: "5:2", name: "cache",
             desc: "cache opt"
             resval: "0"
           },
           { bits: "6", name: "lock",
             desc: "lock opt"
             resval: "0"
           },
           { bits: "9:7", name: "prot",
             desc: "prot opt"
             resval: "0"
           },
           { bits: "13:10", name: "qos",
             desc: "qos opt"
             resval: "0"
           }
           { bits: "17:14", name: "region",
             desc: "region opt"
             resval: "0"
           }
          ]
        },
        { name: "opt_dst",
          desc: "dst options",
          swaccess: "rw",
          hwaccess: "hro",
          fields: [
           { bits: "1:0", name: "burst",
             desc: "burst opt"
             resval: "1"
           },
           { bits: "5:2", name: "cache",
             desc: "cache opt"
             resval: "0"
           },
           { bits: "6", name: "lock",
             desc: "lock opt"
             resval: "0"
           },
           { bits: "9:7", name: "prot",
             desc: "prot opt"
             resval: "0"
           },
           { bits: "13:10", name: "qos",
             desc: "qos opt"
             resval: "0"
           }
           { bits: "17:14", name: "region",
             desc: "region opt"
             resval: "0"
           }
          ]
        }, 
        {  name: "beo",
           desc: "backend options",
           swaccess: "rw",
           hwaccess: "hro",
           fields: [
            { bits: "0", name: "decouple_aw",
              desc: "aw decouple enable"
              resval: "0"
            },
            { bits: "1", name: "decouple_rw",
              desc: "rw decouple enable"
              resval: "0"
            },
            { bits: "4:2", name: "src_max_llen",
              desc: "source max length"
              resval: "0"
            },
            { bits: "7:5", name: "dst_max_llen",
              desc: "destination max length"
              resval: "0"
            },
            { bits: "8", name: "src_reduce_len",
              desc: "srouce reduce length"
              resval: "0"
            }
            { bits: "9", name: "dst_reduce_len",
              desc: "destination reduce length"
              resval: "0"
            }
           ]
        },   
        { name:"last",
          desc: "last transfer",
          swaccess: "rw",
          hwaccess: "hrw",
          fields: [
            { bits: "0",
              name: "last",
              desc: "last transfer"
            }
          ]
        },
        { name:"req_valid",
          desc: "idma request valid",
          swaccess: "rw",
          hwaccess: "hrw",
          fields: [
            { bits: "0",
              name: "req_valid",
              desc: "valid idma request"
              resval: "0"
            }
          ]
        },
        { name:"req_ready",
          desc: "idma request ready",
          swaccess: "ro",
          hwaccess: "hrw",
          fields: [
            { bits: "0",
              name: "req_ready",
              desc: "idma request ready"
              resval: "0"
            }
          ]
        },
        { name:"rsp_ready",
          desc: "idma response ready",
          swaccess: "rw",
          hwaccess: "hrw",
          fields: [
            { bits: "0",
              name: "rsp_ready",
              desc: "idma response ready"
              resval: "0"
            }
          ]
        },
        { name:"rsp_valid",
          desc: "idma response valid",
          swaccess: "ro",
          hwaccess: "hrw",
          fields: [
            { bits: "0",
              name: "rsp_valid",
              desc: "idma response valid"
              resval: "0"
            }
          ]
        },
        { name: "dma_rx_en",
          desc: "this signal indicates dma can be configured now",
          swaccess: "ro",
          hwaccess: "hwo",
          fields: [
              { bits: "0", name: "dma_rx_en",
                desc: "dma can be configured now"
                resval: "0"
              }
          ]
        },
  ]
}









