{
    name: "eth_idma",
    clock_primary: "msoc_clk",
    reset_primary: "rst_int",
    bus_interfaces: [
        { protocol: "reg_iface", direction: "device"}
    ]
    regwidth: "32",
    registers: [
        { name: "low_addr",
          desc: "lower 4 bytes of the devices MAC address",
          swaccess: "rw",
          hwaccess: "hrw",
          fields: [
              { bits: "31:0", name: "lower_mac_address",
                desc: "Lower 32 bit of the devices MAC address"
                resval: "0x00890702"
              }
          ]
        },
        { name: "machi",
          desc: "upper 2 bytes of the devices MAC address, cooked, loopback, promiscuous flag, irq_en",
          swaccess: "rw",
          hwaccess: "hrw",
          fields: [
              { bits: "15:0", name: "upper_addr",
                desc: "Upper 16 bit of the devices MAC address",
                resval: "0x2301"
              },
              { bits: "16", name: "cooked",
                desc: "obsolete flag",
                resval: "0"
              },
              { bits: "17", name: "loopback",
                desc: "enable the reception of loopback packet",
                resval: "0"
              },

              { bits: "21:18", name: "spare",
                desc: "promiscuous flag",
                resval: "0"
              },
              { bits: "22", name: "promiscuous",
                desc: "enable the reception of all packets",
                swaccess: "rw",
                hwaccess: "hro"
              },
              { bits: "23", name: "irq_en",
                desc: "interrupt enbale",
                swaccess: "rw",
                hwaccess: "hro"
              }
          ]
        },
        { name: "mdio",
          desc: "mdio control register",
          swaccess: "rw",
          hwaccess: "hrw",
          fields: [
              { bits: "0", name: "mdio_clk",
                desc: "MDIO clk",
                resval: "0"
              },
              { bits: "1", name: "mdio_o",
                desc: "MDIO output",
                resval: "0"
              },
              { bits: "2", name: "mdio_oe",
                desc: "MDIO output enable",
                resval: "0"
              },
              { bits: "3", name: "mdio_i",
                desc: "MDIO input",
                swaccess: "ro",
                hwaccess: "hrw"
              }
          ]
        },
        { name: "tx_busy",
          desc: "TX busy",
          swaccess: "ro",
          hwaccess: "hwo",
          fields: [
              { bits: "0", name: "tx_busy",
                desc: "TX busy transmitting packets"
                resval: "0"
              }
          ]
        },
        { name: "tx_fcs",
          desc: "TX frame check register",
          swaccess: "ro",
          hwaccess: "hwo",
          fields: [
              { bits: "31:0", name: "tx_fcs",
                desc: "FCS TX status"
                resval: "0"
              }
          ]
        },
        { name: "rx_fcs",
          desc: "RX frame check register",
          swaccess: "ro",
          hwaccess: "hwo",
          fields: [
              { bits: "31:0", name: "rx_fcs",
                desc: "FCS RX status"
                resval: "0"
              }
          ]
        },
        { name: "rsr",
          desc: "receive status register",
          fields: [
              { bits: "0", name: "rx_complete",
                desc: "reception completes"
                resval: "0"
                swaccess: "ro",
                hwaccess: "hwo"
              },
              { bits: "1", name: "rx_irq",
                desc: "etherent rx interrupt"
                resval: "0"
                swaccess: "ro",
                hwaccess: "hwo"
              }
          ]
        },
        { name: "src_addr_low"
          desc: "Low source address",
          swaccess: "rw",
          hwaccess: "hro",
          fields: [
            { bits: "31:0",
              name: "src_addr_low",
              desc: "Low source address",
              resval: "0"
            }
          ]
        },
        { name: "src_addr_high"
          desc: "High source address",
          swaccess: "rw",
          hwaccess: "hro",
          fields: [
            { bits: "31:0",
              name: "src_addr_high",
              desc: "High source address",
              resval: "0"
            }
          ]
        },
        { name: "dst_addr_low"
          desc: "Low destination address",
          swaccess: "rw",
          hwaccess: "hro",
          fields: [
            { bits: "31:0",
              name: "dst_addr_low",
              desc: "Low destination address",
              resval: "0"
            }
          ]
        },
        { name: "dst_addr_high"
          desc: "High destination address",
          swaccess: "rw",
          hwaccess: "hro",
          fields: [
            { bits: "31:0",
              name: "dst_addr_high",
              desc: "High destination address",
              resval: "0"
            }
          ]
        },
        { name: "length_low"
          desc: "Low transfer length in byte",
          swaccess: "rw",
          hwaccess: "hrw",
          fields: [
            { bits: "31:0",
              name: "length_low",
              desc: "Low transfer length in byte",
              resval: "0"
            }
          ]
        },
        { name: "length_high"
          desc: "High transfer length in byte",
          swaccess: "rw",
          hwaccess: "hrw",
          fields: [
            { bits: "31:0",
              name: "length_high",
              desc: "High transfer length in byte",
              resval: "0"
            }
          ]
        },
        { name: "conf",
          desc: "Configuration Register for DMA settings",
          swaccess: "rw",
          hwaccess: "hro",
          fields: [
            { bits: "0",
              name: "decouple_aw",
              desc: "Decouple R-AW"
            },
            { bits: "1",
              name: "decouple_rw",
              desc: "Decouple R-W"
            },
            { bits: "2",
              name: "src_reduce_len",
              desc: "Reduce maximal source burst length"
            },
            { bits: "3",
              name: "dst_reduce_len",
              desc: "Reduce maximal destination burst length"
            }
            { bits: "6:4",
              name: "src_max_llen",
              desc: "Maximal logarithmic source burst length"
            }
            { bits: "9:7",
              name: "dst_max_llen",
              desc: "Maximal logarithmic destination burst length"
            }
            { bits: "10:10",
              name: "enable_nd",
              desc: "ND-extension enabled"
            }
            { bits: "13:11",
              name: "src_protocol",
              desc: "Selection of the source protocol"
            }
            { bits: "16:14",
              name: "dst_protocol",
              desc: "Selection of the destination protocol"
            }
          ]
        },
        { name:"req_valid",
          desc: "idma request valid",
          swaccess: "rw",
          hwaccess: "hrw",
          fields: [
            { bits: "0",
              name: "req_valid",
              desc: "valid idma request"
              resval: "0"
            }
          ]
        },
        { name:"req_ready",
          desc: "idma request ready",
          swaccess: "ro",
          hwaccess: "hrw",
          fields: [
            { bits: "0",
              name: "req_ready",
              desc: "idma request ready"
              resval: "0"
            }
          ]
        },
        { name:"rsp_ready",
          desc: "idma response ready",
          swaccess: "ro",
          hwaccess: "hrw",
          fields: [
            { bits: "0",
              name: "rsp_ready",
              desc: "idma response ready"
              resval: "0"
            }
          ]
        },
        { name:"rsp_valid",
          desc: "idma response valid",
          swaccess: "rw",
          hwaccess: "hrw",
          fields: [
            { bits: "0",
              name: "rsp_valid",
              desc: "idma response valid"
              resval: "0"
            }
          ]
        },
        { name:"rx_end_clr",
          desc: "to clear reception completes",
          swaccess: "wo",
          hwaccess: "hro",
          fields: [
            { bits: "0", name: "rx_end_clr",
              desc: "to clear reception completes"
              resval: "0"
              swaccess: "wo",
              hwaccess: "hro"
            }
          ]
        },
        { name:"rsp_valid_clr",
          desc: "for sw to clear rsp_valid once read",
          swaccess: "wo",
          hwaccess: "hro",
          fields: [
            { bits: "0", name: "rsp_valid_clr",
              desc: "for sw to clear rsp_valid once read"
              resval: "0"
              swaccess: "wo",
              hwaccess: "hro"
            }
          ]
        },
  ]
}
