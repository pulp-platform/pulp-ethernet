{
    name: "eth_idma",
    clock_primary: "msoc_clk",
    reset_primary: "rst_int",
    bus_interfaces: [
        { protocol: "reg_iface", direction: "device"}
    ]
    regwidth: "64",
    registers: [
        { name: "maclo_addr",
          desc: "lower 4 bytes of the devices MAC address",
          swaccess: "rw",
          hwaccess: "hro",
          fields: [
              { bits: "31:0", name: "lower_mac_address",
                desc: "Lower 32 bit of the devices MAC address"
                resval: "8980226"
              }
          ]
        },
        { name: "machi_mdio",
          desc: "upper 2 bytes of the devices MAC address, promiscuous flag, MDIO interface",
          swaccess: "rw",
          hwaccess: "hro",
          fields: [
              { bits: "15:0", name: "upper_mac_address",
                desc: "Upper 16 bit of the devices MAC address"
                resval: "8961"
              },
              { bits: "16", name: "promiscuous",
                desc: "promiscuous flag"
              },
              { bits: "17", name: "phy_mdclk",
                desc: "MDIO clock"
              },
              { bits: "18", name: "phy_mdio_o",
                desc: "MDIO output"
              },
              { bits: "19", name: "phy_mdio_oe",
                desc: "MDIO output enable"
              }
          ]
        },
        { name: "tx_fcs",
          desc: "The FCS TX status",
          swaccess: "ro",
          hwaccess: "hwo",
          fields: [
              { bits: "31:0", name: "tx_fcs_reg",
                desc: "FCS TX status"
              }
          ]
        },
        { name: "rx_fcs",
          desc: "The FCS RX status",
          swaccess: "ro",
          hwaccess: "hwo",
          fields: [
              { bits: "31:0", name: "rx_fcs_reg",
                desc: "FCS RX status"
              }
          ]
        },
        { name: "src_addr",
          desc: "Source Address",
          swaccess: "rw",
          hwaccess: "hro",
          fields: [
            { bits: "31:0",
              name: "src_addr",
              desc: "Source Address"
              resval: "0000"
            }
          ]
        },
        { name: "dst_addr",
          desc: "Destination Address",
          swaccess: "rw",
          hwaccess: "hro",
          fields: [
            { bits: "31:0",
              name: "dst_addr",
              desc: "Destination Address"
              resval: "0000"
            }
          ]
        },
        { name: "length",
          desc: "Number of bytes",
          swaccess: "rw",
          hwaccess: "hro",
          fields: [
            { bits: "31:0",
              name: "num_bytes",
              desc: "Number of bytes"
              resval: "0000"
            }
          ]
        },
        { name: "src_protocol",
          desc: "Source protocol of iDMA",
          swaccess: "rw",
          hwaccess: "hro",
          fields: [
            { bits: "2:0",
              name: "src_protocol",
              desc: "iDMA source protocol"
              resval: "000"
            }
          ]
        },
        { name: "dst_protocol",
          desc: "Destination protocol of iDMA",
          swaccess: "rw",
          hwaccess: "hro",
          fields: [
            { bits: "2:0",
              name: "dst_protocol",
              desc: "iDMA destination protocol "
              resval: "000"
            }
          ]
        },
        { name: "axi_id",
          desc: "iDMA transaction ID",
          swaccess: "rw",
          hwaccess: "hrw",
          fields: [
            { bits: "0",
              name: "axi_id",
              desc: "transaction ID"
              resval: "0"
            }
          ]
        },
        { name: "opt_src",
          desc: "src options",
          swaccess: "rw",
          hwaccess: "hro",
          fields: [
           { bits: "1:0", name: "burst",
             desc: "burst opt"
             resval: "1"
           },
           { bits: "5:2", name: "cache",
             desc: "cache opt"
             resval: "0"
           },
           { bits: "6", name: "lock",
             desc: "lock opt"
             resval: "0"
           },
           { bits: "9:7", name: "prot",
             desc: "prot opt"
             resval: "0"
           },
           { bits: "13:10", name: "qos",
             desc: "qos opt"
             resval: "0"
           }
           { bits: "17:14", name: "region",
             desc: "region opt"
             resval: "0"
           }
          ]
        },
        { name: "opt_dst",
          desc: "dst options",
          swaccess: "rw",
          hwaccess: "hro",
          fields: [
           { bits: "1:0", name: "burst",
             desc: "burst opt"
             resval: "1"
           },
           { bits: "5:2", name: "cache",
             desc: "cache opt"
             resval: "0"
           },
           { bits: "6", name: "lock",
             desc: "lock opt"
             resval: "0"
           },
           { bits: "9:7", name: "prot",
             desc: "prot opt"
             resval: "0"
           },
           { bits: "13:10", name: "qos",
             desc: "qos opt"
             resval: "0"
           }
           { bits: "17:14", name: "region",
             desc: "region opt"
             resval: "0"
           }
          ]
        }, 
        {  name: "beo",
           desc: "backend options",
           swaccess: "rw",
           hwaccess: "hro",
           fields: [
            { bits: "0", name: "decouple_aw",
              desc: "aw decouple enable"
              resval: "0"
            },
            { bits: "1", name: "decouple_rw",
              desc: "rw decouple enable"
              resval: "0"
            },
            { bits: "4:2", name: "src_max_llen",
              desc: "source max length"
              resval: "0"
            },
            { bits: "7:5", name: "dst_max_llen",
              desc: "destination max length"
              resval: "0"
            },
            { bits: "8", name: "src_reduce_len",
              desc: "srouce reduce length"
              resval: "0"
            }
            { bits: "9", name: "dst_reduce_len",
              desc: "destination reduce length"
              resval: "0"
            }
           ]
        },   
        { name:"last",
          desc: "last transfer",
          swaccess: "rw",
          hwaccess: "hrw",
          fields: [
            { bits: "0",
              name: "last",
              desc: "last transfer"
            }
          ]
        },
        { name:"req_valid",
          desc: "idma request valid",
          swaccess: "rw",
          hwaccess: "hro",
          fields: [
            { bits: "0",
              name: "req_valid",
              desc: "valid idma request"
              resval: "0"
            }
          ]
        },
        { name:"req_ready",
          desc: "idma request ready",
          swaccess: "ro",
          hwaccess: "hrw",
          fields: [
            { bits: "0",
              name: "req_ready",
              desc: "idma request ready"
              resval: "0"
            }
          ]
        },
        { name:"rsp_ready",
          desc: "idma response ready",
          swaccess: "rw",
          hwaccess: "hro",
          fields: [
            { bits: "0",
              name: "rsp_ready",
              desc: "idma response ready"
              resval: "0"
            }
          ]
        },
        { name:"rsp_valid",
          desc: "idma response valid",
          swaccess: "ro",
          hwaccess: "hrw",
          fields: [
            { bits: "0",
              name: "rsp_valid",
              desc: "idma response valid"
              resval: "0"
            }
          ]
        },
  ]
}





